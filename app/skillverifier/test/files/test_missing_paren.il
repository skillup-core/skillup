procedure(test1(x)
  if(!x then
    printf("not x\n")
  )
)

procedure(test2(x)
  if(x == nil then
    printf("nil\n")
  )
)
