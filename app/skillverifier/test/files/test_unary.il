procedure(test(x)
  let( ((y !x))
    printf("%L\n" y)
  )
)
