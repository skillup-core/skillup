procedure(a(b c)
let((d e)
  d = lambda((e)
    foreach(i e~>?
      err += i
    )
  )
))

procedure(b()
let(()
  foreach(b c~>?
    d = 1
  )
))

procedure(c()
let(()
  foreach(err err
    t
  )
))

procedure(d(e)
let(()
  if(e = 1 then t)
  unless(e = 3 t)
))
