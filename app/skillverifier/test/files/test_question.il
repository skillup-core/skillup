procedure(test()
  geOpen(?lib "foo" ?cell "bar")
)
