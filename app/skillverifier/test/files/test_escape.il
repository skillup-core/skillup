procedure(test()
  caseq(v
    (\( printf("open paren\n"))
    (\) printf("close paren\n"))
    (\< printf("less than\n"))
    (a printf("letter a\n"))
  )
)
