procedure(test(obj)
  let( ((x obj~>a~>b~>c))
    printf("%L\n" x)
  )
)
