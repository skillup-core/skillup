procedure(test(masterId)
  if(masterId~>prBoundary~>isRectangle
     printf("yes\n")
     printf("no\n")
  )
)
