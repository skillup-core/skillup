procedure(test()
  caseq(state
    (init printf("init\n"))
    (done printf("done\n"))
  )
)
